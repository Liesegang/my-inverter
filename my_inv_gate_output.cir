* Created by KLayout

* cell TOP
.SUBCKT TOP
* net 3 vout
* net 4 vss
* cell instance $1 r0 *1 -2.4,-8.7
X$1 4 3 1 4 MN$1
* cell instance $2 r0 *1 -2.4,14
X$2 2 3 1 2 MP$1
.ENDS TOP

* cell MP$1
* pin
* pin
* pin
* pin
.SUBCKT MP$1 1 2 3 4
* device instance $1 r0 *1 3.3,5.3 PMOS
M$1 2 3 1 4 PMOS L=1U W=3.4U AS=9.52P AD=9.52P PS=12.4U PD=12.4U
.ENDS MP$1

* cell MN$1
* pin
* pin
* pin
* pin SUBSTRATE
.SUBCKT MN$1 1 2 3 4
* net 4 SUBSTRATE
* device instance $1 r0 *1 3.3,5.3 NMOS
M$1 2 3 1 4 NMOS L=1U W=3.4U AS=9.52P AD=9.52P PS=12.4U PD=12.4U
.ENDS MN$1
